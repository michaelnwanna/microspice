* A 10 V source and two equal resistors produce 5 V at out.
V1 in 0 DC 10
R1 in out 1k
R2 out 0 1k
.end
